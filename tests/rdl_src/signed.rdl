addrmap top {
    default accesswidth = 64;
    default regwidth = 64;

    reg {
        field {
            sw = rw; hw = w;
            is_signed;
        } f_signed[16] = 0;

        field {
            sw = rw; hw = w;
            is_signed;
        } f_signed2[13] = 0;

        field {
            sw = rw; hw = r;
            is_signed = false;
        } f_unsigned[16] = 0;

        field {
            sw = rw; hw = w;
        } f_no_sign[16];
    } r1 @ 0x0;

    reg {
        field {
            sw = rw; hw = r;
            is_signed;
        } f_large_signed[64] = 64'hFFFF_FFFF_FFFF_FFFF;
    } r2 @ 0x8;

    reg {
        field {
            sw = r; hw = w;
            is_signed;
        } f_single_bit_signed;

        field {
            sw = rw; hw = r;
            is_signed = false;
        } f_single_bit_unsigned = 1;

        field {
            sw = r; hw = r;
            is_signed;
        } f_constant_signed[3] = 3'd6;

        field {
            sw = r; hw = r;
            is_signed = false;
        } f_constant_unsigned[3] = 3'd2;
    } r3 @ 0x10;
};
