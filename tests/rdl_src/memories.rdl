addrmap memories {

    external mem {
        mementries = 2;
        memwidth = 32;
        sw = w;
    } mem_2_32_w;

    external mem {
        mementries = 2;
        memwidth = 32;
        sw = r;
    } mem_2_32_r;

    external mem {
        mementries = 2;
        memwidth = 32;
        sw = rw;
    } mem_2_32_rw;

    external mem {
        mementries = 5;
        memwidth = 64;
        sw = w;
    } mem_5_64_w;

    external mem {
        mementries = 5;
        memwidth = 64;
        sw = r;
    } mem_5_64_r;

    external mem {
        mementries = 5;
        memwidth = 64;
        sw = rw;
    } mem_5_64_rw;

    external mem {
        mementries = 5;
        memwidth = 64;
        sw = rw;
    } mem_array[3] += 0x100;

    reg virt_reg {
        field {} a;
        field {} b[31:1];
    };

    external mem {
        mementries = 5;
        memwidth = 32;
        sw = rw;
        reg virt1_t {
            regwidth = 32;
            accesswidth = 32;
            field {} a;
            field {} b[31:1];
        };
        virt1_t virt;
        virt_reg virt2[4];
    } mem_virt_registers;
};
